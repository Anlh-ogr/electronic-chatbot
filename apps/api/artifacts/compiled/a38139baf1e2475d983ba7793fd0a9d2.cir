* Auto-generated by NgspiceCompilerService
Q1 N_COLLECTOR N_BASE N_EMITTER QNPN
R1 +12V N_BASE 180k
R2 N_BASE 0 39k
RC +12V N_COLLECTOR 4.7k
RE1 N_EMITTER N_EMITTER_BYPASS 470
RE2 N_EMITTER_BYPASS 0 820
C1 IN N_BASE 1uF
C2 N_COLLECTOR OUT 1uF
CE N_EMITTER_BYPASS 0 100uF
RJ1 IN 0 CONN_01X02
RJ2 OUT 0 CONN_01X02
RVCC_PORT +12V 0 +12V
RGND_PORT 0 0 GND
.model QNPN NPN(BF=180 IS=1e-14 VAF=100)
VTB IN 0 SINE(0 1 1k)
.tran 1u 5m
.control
run
wrdata output.tsv v(IN) v(OUT)
write output.raw
quit
.endc
.end
