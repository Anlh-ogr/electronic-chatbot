* Auto-generated by NgspiceCompilerService
RVCC VCC 0 1k
RGND 0 0 1k
RIN NET_INPUT_CONNECTOR 0 1k
ROUT NET_OUTPUT_CONNECTOR 0 1k
Q1 NET_COLLECTOR NET_BASE NET_EMITTER_TOTAL QNPN
R1 VCC NET_BASE 47k
R2 NET_BASE 0 12k
RC VCC NET_COLLECTOR 2.2k
RE1 NET_EMITTER_TOTAL NET_EMITTER_BYPASS_POINT 680
RE2 NET_EMITTER_BYPASS_POINT 0 100
C_IN NET_INPUT_CONNECTOR NET_BASE 2.2uF
C_OUT NET_COLLECTOR NET_OUTPUT_CONNECTOR 4.7uF
CE NET_EMITTER_BYPASS_POINT 0 22uF
.model QNPN NPN(BF=180 IS=1e-14 VAF=100)
VVCC VCC 0 DC +12
VTB NET_INPUT_CONNECTOR 0 SINE(0 1 1k)
.tran 1u 5m
.control
run
wrdata output.tsv v(NET_INPUT_CONNECTOR) v(NET_OUTPUT_CONNECTOR)
write output.raw
quit
.endc
.end
