* Auto-generated by NgspiceCompilerService
RVCC VCC 0 1k
RGND 0 0 1k
RIN IN_SIGNAL 0 1k
ROUT OUT_SIGNAL 0 1k
Q1 COLLECTOR_NODE BASE_NODE EMITTER_NODE_1 QNPN
R1 VCC BASE_NODE 100k
R2 BASE_NODE 0 22k
RC VCC COLLECTOR_NODE 3k
RE1 EMITTER_NODE_1 EMITTER_NODE_2 150
RE2 EMITTER_NODE_2 0 620
CIN IN_SIGNAL BASE_NODE 1uF
COUT COLLECTOR_NODE OUT_SIGNAL 10uF
CE EMITTER_NODE_2 0 100uF
C_VCC VCC 0 0.1uF
.model QNPN NPN(BF=180 IS=1e-14 VAF=100)
VVCC VCC 0 DC +12
VTB IN_SIGNAL 0 SINE(0 1 1k)
.tran 1u 5m
.control
run
wrdata output.tsv v(IN_SIGNAL) v(OUT)
write output.raw
quit
.endc
.end
