* Auto-generated by NgspiceCompilerService
R1 +12V V_DRIVER_BASE 82k
R2 V_DRIVER_BASE 0 15k
R3 V_DRIVER_EMITTER 0 1k
R4 +12V V_DRIVER_COLLECTOR 12k
R5 -12V V_BIAS_BOTTOM 4.7k
R6 V_DRIVER_COLLECTOR V_BIAS_TOP 100
R7 V_BIAS_MID OUT 0.22
R8 V_BIAS_BOTTOM OUT 0.22
Q1 +12V V_BIAS_MID OUT QNPN
Q2 -12V V_BIAS_BOTTOM OUT QPNP
Q3 V_DRIVER_COLLECTOR V_DRIVER_BASE V_DRIVER_EMITTER QNPN
D1 V_BIAS_TOP V_BIAS_MID DDEFAULT
D2 V_BIAS_MID V_BIAS_BOTTOM DDEFAULT
C1 IN 0 1uF
C2 +12V 0 100uF
C3 -12V 0 100uF
C4 +12V 0 0.1uF
C5 -12V 0 0.1uF
RL OUT 0 8
.model QNPN NPN(BF=180 IS=1e-14 VAF=100)
.model QPNP PNP(BF=120 IS=1e-14 VAF=80)
.model DDEFAULT D(IS=1e-14 N=1.9)
VTB IN 0 SINE(0 1 1k)
.tran 1u 5m
.control
run
wrdata output.tsv v(IN) v(OUT)
write output.raw
quit
.endc
.end
