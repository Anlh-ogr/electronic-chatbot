* Auto-generated by NgspiceCompilerService
R1 IN GATE 100k
R2 IN GATE 10k
RD VCC OUT 5k
RVCC VCC 0 1k
RGND 0 0 1k
RCIN IN 0 1
RCOUT OUT 0 1
VVCC VCC 0 DC 12
VTB IN 0 SINE(0 1 1k)
.tran 1u 5m
.control
run
wrdata output.tsv v(IN) v(OUT)
write output.raw
quit
.endc
.end
