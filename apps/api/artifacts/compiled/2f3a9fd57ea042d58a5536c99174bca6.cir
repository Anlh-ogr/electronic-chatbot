* Auto-generated by NgspiceCompilerService
Q1 Q1_BASE Q1_COLLECTOR Q1_EMITTER QNPN
R1 VCC Q1_BASE 180k
R2 Q1_BASE 0 39k
RC VCC Q1_COLLECTOR 5.6k
RE1 Q1_EMITTER RE_JUNCTION 560
RE2 RE_JUNCTION 0 680
C1 IN Q1_BASE 1u
C2 Q1_COLLECTOR OUT 1u
CE RE_JUNCTION 0 220u
RVCC VCC 0 +12V
RGND 0 0 GND
.model QNPN NPN(BF=180 IS=1e-14 VAF=100)
VTB IN 0 SINE(0 1 1k)
.tran 1u 5m
.control
run
wrdata output.tsv v(IN) v(OUT)
write output.raw
quit
.endc
.end
