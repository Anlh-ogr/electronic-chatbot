* Auto-generated by NgspiceCompilerService
Q1 OUT EMITTER OUT QNPN
RC VCC OUT 1k
RE1 EMITTER 0 100
RE2 EMITTER BYPASS 470
CE EMITTER BYPASS 10uF
RVCC VCC 0 12V
RGND 0 0 0
.model QNPN NPN(BF=180 IS=1e-14 VAF=100)
VTB VCC 0 SINE(0 1 1k)
.tran 1u 5m
.control
run
wrdata output.tsv v(VCC) v(OUT)
write output.raw
quit
.endc
.end
