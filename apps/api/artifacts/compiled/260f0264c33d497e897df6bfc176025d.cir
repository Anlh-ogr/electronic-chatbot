* Auto-generated by NgspiceCompilerService
Q1 BASE COL EMIT QNPN
R1 VCC BASE 10k
R2 BASE 0 2.2k
R3 VCC COL 2.2k
R4 EMIT 0 470
C1 IN BASE 10uF
C2 EMIT 0 100uF
C3 COL OUT 10uF
.model QNPN NPN(BF=180 IS=1e-14 VAF=100)
VTB IN 0 SINE(0 1 1k)
.tran 1u 5m
.control
run
wrdata output.tsv v(IN) v(OUT)
write output.raw
quit
.endc
.end
