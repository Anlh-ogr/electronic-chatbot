* Auto-generated by NgspiceCompilerService
RVCC VCC_NET 0 1k
RGND GND_NET 0 1k
RIN INPUT_SIGNAL 0 1k
ROUT OUTPUT_SIGNAL 0 1k
Q1 COLLECTOR_NODE BASE_NODE EMITTER_NODE QNPN
R1 VCC_NET BASE_NODE 100k
R2 BASE_NODE GND_NET 18k
RC VCC_NET COLLECTOR_NODE 4.7k
RE1 EMITTER_NODE GND_NET 750
RE2 EMITTER_NODE GND_NET 220
C_IN INPUT_SIGNAL BASE_NODE 1uF
C_OUT COLLECTOR_NODE OUTPUT_SIGNAL 2.2uF
C_E EMITTER_NODE GND_NET 470uF
.model QNPN NPN(BF=180 IS=1e-14 VAF=100)
VTB INPUT_SIGNAL 0 SINE(0 1 1k)
.tran 1u 5m
.control
run
wrdata output.tsv v(INPUT_SIGNAL) v(OUT)
write output.raw
quit
.endc
.end
