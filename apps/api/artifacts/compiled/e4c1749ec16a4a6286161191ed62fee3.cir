* Auto-generated by NgspiceCompilerService
RVCC VCC 0 12V
RGND 0 0 0V
RIN NET_INPUT 0 Input
ROUT NET_OUTPUT 0 Output
Q1 NET_COLLECTOR NET_BASE NET_EMITTER QNPN
R1 VCC NET_BASE 47k
R2 NET_BASE 0 10k
RC VCC NET_COLLECTOR 3k
RE1 NET_EMITTER 0 620
RE2 NET_EMITTER 0 130
C_IN NET_INPUT NET_BASE 4.7uF
C_OUT NET_COLLECTOR NET_OUTPUT 2.2uF
C_E NET_EMITTER 0 100uF
C_VCC VCC 0 0.1uF
.model QNPN NPN(BF=180 IS=1e-14 VAF=100)
VTB IN 0 SINE(0 1 1k)
.tran 1u 5m
.control
run
wrdata output.tsv v(IN) v(OUT)
write output.raw
quit
.endc
.end
