* Auto-generated by NgspiceCompilerService
Q1 COL BASE EMIT QNPN
R1 BASE VCC 47k
R2 BASE 0 10k
RC VCC COL 1k
RE1 EMIT RE_NODE 37
RE2 RE_NODE 0 100
C3 RE_NODE 0 100uF
C1 IN BASE 10uF
C2 COL OUT 10uF
RVCC VCC 0 1k
RGND 0 0 1k
RIN IN 0 0
ROUT OUT 0 0
.model QNPN NPN(BF=180 IS=1e-14 VAF=100)
VVCC VCC 0 DC 12
VTB IN 0 SINE(0 1 1k)
.tran 1u 5m
.control
run
wrdata output.tsv v(IN) v(OUT)
write output.raw
quit
.endc
.end
