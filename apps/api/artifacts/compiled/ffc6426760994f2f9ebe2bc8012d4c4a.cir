* Auto-generated by NgspiceCompilerService
Q1 BASE COLLECTOR EMITTER_DEGEN QNPN
R1 +12V BASE 180k
R2 BASE 0 39k
RC +12V COLLECTOR 6.2k
RE1 EMITTER_DEGEN EMITTER_BYPASS 620
RE2 EMITTER_BYPASS 0 560
C1 IN BASE 1u
C2 COLLECTOR OUT 1u
CE EMITTER_BYPASS 0 220u
RVCC +12V 0 +12V
RGND 0 0 GND
.model QNPN NPN(BF=180 IS=1e-14 VAF=100)
VTB IN 0 SINE(0 1 1k)
.tran 1u 5m
.control
run
wrdata output.tsv v(IN) v(OUT)
write output.raw
quit
.endc
.end
