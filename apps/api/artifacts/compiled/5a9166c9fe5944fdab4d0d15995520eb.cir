* Auto-generated by NgspiceCompilerService
RVCC VCC 0 12V
RGND 0 0 0V
RIN IN_SIGNAL 0 Input
ROUT OUT_SIGNAL 0 Output
Q1 COLLECTOR BASE EMITTER QNPN
R1 VCC BASE 100k
R2 BASE 0 22k
RC VCC COLLECTOR 2.7k
RE1 EMITTER 0 620
RE2 EMITTER EMITTER_BYPASS 130
CIN IN_SIGNAL BASE 1uF
COUT COLLECTOR OUT_SIGNAL 1uF
CE EMITTER_BYPASS 0 1000uF
C_DEC VCC 0 0.1uF
.model QNPN NPN(BF=180 IS=1e-14 VAF=100)
VTB IN 0 SINE(0 1 1k)
.tran 1u 5m
.control
run
wrdata output.tsv v(IN) v(OUT)
write output.raw
quit
.endc
.end
