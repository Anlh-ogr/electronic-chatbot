* Auto-generated by NgspiceCompilerService
Q1 VCC IN OUT QNPN
Q2 VEE IN OUT QPNP
RL OUT 0 8
RVCC VCC 0 1k
RVEE VEE 0 -12V
RGND 0 0 1k
RIN IN 0 1
ROUT OUT 0 1
.model QNPN NPN(BF=180 IS=1e-14 VAF=100)
.model QPNP PNP(BF=120 IS=1e-14 VAF=80)
VVCC VCC 0 DC 12
VTB IN 0 SINE(0 1 1k)
.tran 1u 5m
.control
run
wrdata output.tsv v(IN) v(OUT)
write output.raw
quit
.endc
.end
