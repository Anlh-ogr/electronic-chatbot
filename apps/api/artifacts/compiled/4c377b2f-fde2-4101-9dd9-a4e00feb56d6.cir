* Auto-generated by NgspiceCompilerService
Q1 COLLECTOR BASE EMITTER QNPN
R1 VCC BASE 47k
R2 BASE 0 10k
RC VCC COLLECTOR 2.2k
RE1 EMITTER 0 220
RE2 EMITTER 0 100
CE EMITTER 0 100uF
CIN IN_NET BASE 10uF
COUT COLLECTOR OUT_NET 10uF
RVCC VCC 0 12V
RGND 0 0 0V
RIN IN_NET 0 0
ROUT OUT_NET 0 0
.model QNPN NPN(BF=180 IS=1e-14 VAF=100)
VTB IN 0 SINE(0 1 1k)
.tran 1u 5m
.control
run
wrdata output.tsv v(IN) v(OUT)
write output.raw
quit
.endc
.end
