* Auto-generated by NgspiceCompilerService
RVCC VCC 0 1k
RGND 0 0 1k
RIN IN_SIGNAL 0 1k
ROUT OUT_SIGNAL 0 1k
Q1 COLLECTOR BASE_BIAS EMITTER QNPN
R1 VCC BASE_BIAS 100k
R2 BASE_BIAS 0 18k
RC VCC COLLECTOR 3k
RE1 EMITTER EMITTER_SPLIT 150
RE2 EMITTER_SPLIT 0 470
CIN IN_SIGNAL BASE_BIAS 1uF
COUT COLLECTOR OUT_SIGNAL 10uF
CE EMITTER_SPLIT 0 100uF
.model QNPN NPN(BF=180 IS=1e-14 VAF=100)
VVCC VCC 0 DC +12
VTB IN_SIGNAL 0 SINE(0 1 1k)
.tran 1u 5m
.control
run
wrdata output.tsv v(IN_SIGNAL) v(OUT_SIGNAL)
write output.raw
quit
.endc
.end
