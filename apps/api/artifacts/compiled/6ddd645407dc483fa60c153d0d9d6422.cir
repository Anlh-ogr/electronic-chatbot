* Auto-generated by NgspiceCompilerService
Q1 EMIT COL COL QNPN
R1 VCC BASE 47k
R2 BASE 0 10k
RC VCC COL 1k
RE1 EMIT 0 100
RE2 EMIT 0 470
CE EMIT 0 100uF
CIN IN BASE 10uF
COUT OUT 0 10uF
RVCC VCC 0 12V
RGND 0 0 0V
.model QNPN NPN(BF=180 IS=1e-14 VAF=100)
VTB IN 0 SINE(0 1 1k)
.tran 1u 5m
.control
run
wrdata output.tsv v(IN) v(OUT)
write output.raw
quit
.endc
.end
