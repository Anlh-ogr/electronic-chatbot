* Auto-generated by NgspiceCompilerService
Q1 NET-Q1-BASE NET-Q1-EMITTER NET-Q1-COLLECTOR QNPN
R1 +12V NET-Q1-BASE 180k
R2 NET-Q1-BASE 0 39k
RC +12V NET-Q1-COLLECTOR 4.7k
RE1 NET-Q1-EMITTER NET-RE1-RE2 470
RE2 NET-RE1-RE2 0 680
C1 IN NET-Q1-BASE 1uF
C2 OUT NET-Q1-COLLECTOR 1uF
CE NET-RE1-RE2 0 220uF
RVCC +12V 0 +12V
RGND 0 0 GND
.model QNPN NPN(BF=180 IS=1e-14 VAF=100)
VTB IN 0 SINE(0 1 1k)
.tran 1u 5m
.control
run
wrdata output.tsv v(IN) v(OUT)
write output.raw
quit
.endc
.end
