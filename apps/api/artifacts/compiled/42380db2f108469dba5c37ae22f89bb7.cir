* Auto-generated by NgspiceCompilerService
Q1 OUT BASE EMITTER QNPN
R1 VCC BASE 10k
R2 BASE 0 2.2k
RC VCC OUT 4.7k
RE1 EMITTER RE_NODE 100
RE2 RE_NODE 0 100
CE RE_NODE 0 10uF
CIN IN BASE 10uF
COUT OUT 0 10uF
RVCC VCC 0 1k
RGND 0 0 1k
RIN IN 0 0
ROUT 0 0 0
.model QNPN NPN(BF=180 IS=1e-14 VAF=100)
VVCC VCC 0 DC 12
VTB IN 0 SINE(0 1 1k)
.tran 1u 5m
.control
run
wrdata output.tsv v(IN) v(OUT)
write output.raw
quit
.endc
.end
