* Auto-generated by NgspiceCompilerService
Q1 Q1_BASE Q1_COLLECTOR Q1_EMITTER_DEGEN QNPN
R1 VCC Q1_BASE 56k
R2 Q1_BASE 0 10k
RC VCC Q1_COLLECTOR 3.3k
RE1 Q1_EMITTER_DEGEN RE_BYPASS_NODE 330
RE2 RE_BYPASS_NODE 0 270
C1 IN Q1_BASE 1u
C2 Q1_COLLECTOR OUT 1u
CE RE_BYPASS_NODE 0 470u
RVCC VCC 0 +12V
RGND 0 0 GND
.model QNPN NPN(BF=180 IS=1e-14 VAF=100)
VTB IN 0 SINE(0 1 1k)
.tran 1u 5m
.control
run
wrdata output.tsv v(IN) v(OUT)
write output.raw
quit
.endc
.end
