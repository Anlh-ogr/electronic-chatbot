* Auto-generated by NgspiceCompilerService
Q1 OUT BASE EMITTER QNPN
R1 BASE VCC 10k
R2 BASE 0 2.2k
RC VCC OUT 2.2k
RE1 EMITTER RE_NODE 82ohm
RE2 RE_NODE 0 100ohm
C1 IN BASE 10uF
C2 OUT 0 10uF
C3 RE_NODE 0 100uF
RVCC VCC 0 12V
RGND 0 0 0V
RIN IN 0 0
ROUT 0 0 0
.model QNPN NPN(BF=180 IS=1e-14 VAF=100)
VTB IN 0 SINE(0 1 1k)
.tran 1u 5m
.control
run
wrdata output.tsv v(IN) v(OUT)
write output.raw
quit
.endc
.end
