* Auto-generated by NgspiceCompilerService
RVCC VCC 0 1k
RGND 0 0 1k
RIN NET_IN 0 1k
ROUT NET_OUT 0 1k
Q1 NET_COLLECTOR NET_BASE NET_EMITTER QNPN
R1 VCC NET_BASE 200k
R2 NET_BASE 0 33k
RC VCC NET_COLLECTOR 5k
RE1 NET_EMITTER_BYPASS 0 750
RE2 NET_EMITTER NET_EMITTER_BYPASS 220
CIN NET_IN NET_BASE 1uF
COUT NET_COLLECTOR NET_OUT 1uF
CE NET_EMITTER NET_EMITTER_BYPASS 10uF
C_DECOUPLING VCC 0 100nF
.model QNPN NPN(BF=180 IS=1e-14 VAF=100)
VVCC VCC 0 DC +12
VTB NET_IN 0 SINE(0 1 1k)
.tran 1u 5m
.control
run
wrdata output.tsv v(NET_IN) v(NET_OUT)
write output.raw
quit
.endc
.end
