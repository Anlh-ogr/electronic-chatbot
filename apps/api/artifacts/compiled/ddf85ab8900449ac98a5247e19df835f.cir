* Auto-generated by NgspiceCompilerService
Q1 BASE EMIT COL QNPN
R1 VCC BASE 47k
R2 BASE 0 10k
RC VCC COL 2.2k
RE EMIT 0 470
C1 IN BASE 10uF
C2 COL 0 10uF
.model QNPN NPN(BF=180 IS=1e-14 VAF=100)
VTB IN 0 SINE(0 1 1k)
.tran 1u 5m
.control
run
wrdata output.tsv v(IN) v(VCC)
write output.raw
quit
.endc
.end
