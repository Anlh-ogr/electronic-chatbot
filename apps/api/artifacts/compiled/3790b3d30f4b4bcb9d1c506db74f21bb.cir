* Auto-generated by NgspiceCompilerService
Q1 BASE COLLECTOR EMITTER QNPN
R1 VCC BASE 47k
R2 BASE 0 10k
RC VCC COLLECTOR 0.1
RE EMITTER 0 100
C1 IN BASE 10uF
C2 EMITTER 0 100uF
C3 COLLECTOR OUT 10uF
.model QNPN NPN(BF=180 IS=1e-14 VAF=100)
VTB IN 0 SINE(0 1 1k)
.tran 1u 5m
.control
run
wrdata output.tsv v(IN) v(OUT)
write output.raw
quit
.endc
.end
