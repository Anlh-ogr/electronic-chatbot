* Auto-generated by NgspiceCompilerService
Q1 N-001_Q1_BASE N-002_Q1_COLLECTOR N-003_Q1_EMITTER QNPN
R1 +12V N-001_Q1_BASE 82k
R2 N-001_Q1_BASE 0 18k
RC +12V N-002_Q1_COLLECTOR 2.4k
RE1 N-003_Q1_EMITTER N-004_RE_NODE 220
RE2 N-004_RE_NODE 0 390
CIN IN N-001_Q1_BASE 10uF
COUT N-002_Q1_COLLECTOR OUT 10uF
CE N-004_RE_NODE 0 220uF
RJ_IN IN 0 CONN_01X02
RJ_OUT OUT 0 CONN_01X02
RPWR +12V 0 CONN_01X02
.model QNPN NPN(BF=180 IS=1e-14 VAF=100)
VTB IN 0 SINE(0 1 1k)
.tran 1u 5m
.control
run
wrdata output.tsv v(IN) v(OUT)
write output.raw
quit
.endc
.end
