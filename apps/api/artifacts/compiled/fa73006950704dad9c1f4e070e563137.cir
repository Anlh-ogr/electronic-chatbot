* Auto-generated by NgspiceCompilerService
Q1 COLLECTOR BASE EMITTER QNPN
R1 VCC BASE 10k
R2 BASE 0 2.2k
RC VCC COLLECTOR 2k
RE1 EMITTER 0 100
RE2 EMITTER 0 470
CE EMITTER 0 100uF
CIN IN BASE 10uF
COUT COLLECTOR OUT 10uF
RVCC VCC 0 1k
RGND 0 0 1k
RIN IN 0 1
ROUT OUT 0 1
.model QNPN NPN(BF=180 IS=1e-14 VAF=100)
VVCC VCC 0 DC +12
VTB IN 0 SINE(0 1 1k)
.tran 1u 5m
.control
run
wrdata output.tsv v(IN) v(OUT)
write output.raw
quit
.endc
.end
