* Auto-generated by NgspiceCompilerService
Q1 COL BASE EMIT QNPN
R1 VCC BASE 47k
R2 BASE 0 10k
RC VCC COL 2k
RE1 EMIT 0 100
C1 IN BASE 10uF
RVCC VCC 0 12V
RGND 0 0 0V
RIN IN 0 1
ROUT COL 0 1
.model QNPN NPN(BF=180 IS=1e-14 VAF=100)
VTB IN 0 SINE(0 1 1k)
.tran 1u 5m
.control
run
wrdata output.tsv v(IN) v(OUT)
write output.raw
quit
.endc
.end
