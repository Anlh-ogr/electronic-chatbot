* Auto-generated by NgspiceCompilerService
RVCC VCC 0 12V
RGND 0 0 0V
RIN IN_NODE 0 Input
ROUT OUT_NODE 0 Output
Q1 COLLECTOR_NODE BASE_NODE EMITTER_NODE QNPN
R1 VCC BASE_NODE 100k
R2 BASE_NODE 0 22k
RC VCC COLLECTOR_NODE 2.7k
RE1 EMITTER_NODE RE_BYPASS_NODE 620
RE2 RE_BYPASS_NODE 0 130
C_IN IN_NODE BASE_NODE 1uF
C_OUT COLLECTOR_NODE OUT_NODE 10uF
C_E RE_BYPASS_NODE 0 470uF
C_DEC VCC 0 0.1uF
.model QNPN NPN(BF=180 IS=1e-14 VAF=100)
VTB IN 0 SINE(0 1 1k)
.tran 1u 5m
.control
run
wrdata output.tsv v(IN) v(OUT)
write output.raw
quit
.endc
.end
