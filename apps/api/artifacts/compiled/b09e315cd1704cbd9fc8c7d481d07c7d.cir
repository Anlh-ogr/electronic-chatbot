* Auto-generated by NgspiceCompilerService
RVCC VCC 0 12V
RGND CE_GND 0 0
Q1 BASE EMITTER COLLECTOR QNPN
R1 VCC BASE 47k
R2 BASE 0 10k
RC VCC COLLECTOR 1k
RE1 EMITTER RE_NODE 74
RE2 RE_NODE 0 100
C1 IN BASE 10uF
C2 COLLECTOR OUT 10uF
CE RE_NODE CE_GND 100uF
.model QNPN NPN(BF=180 IS=1e-14 VAF=100)
VTB IN 0 SINE(0 1 1k)
.tran 1u 5m
.control
run
wrdata output.tsv v(IN) v(OUT)
write output.raw
quit
.endc
.end
