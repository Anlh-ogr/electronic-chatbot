* Auto-generated by NgspiceCompilerService
RVCC VCC 0 12V
RGND 0 0 0V
RIN NET_IN 0 Input
ROUT NET_OUT 0 Output
Q1 NET_COLLECTOR NET_BASE NET_EMITTER_SPLIT QNPN
R1 VCC NET_BASE 100k
R2 NET_BASE 0 22k
RC VCC NET_COLLECTOR 3k
RE1 NET_EMITTER_SPLIT NET_EMITTER 150ohm
RE2 NET_EMITTER 0 600ohm
CIN NET_IN NET_BASE 1uF
COUT NET_COLLECTOR NET_OUT 1uF
CE NET_EMITTER 0 100uF
C_VCC VCC 0 0.1uF
.model QNPN NPN(BF=180 IS=1e-14 VAF=100)
VTB IN 0 SINE(0 1 1k)
.tran 1u 5m
.control
run
wrdata output.tsv v(IN) v(OUT)
write output.raw
quit
.endc
.end
