* Auto-generated by NgspiceCompilerService
Q1 N_MIRROR_REF N_Q1_B N_DIFF_E QNPN
Q2 N_VAS_IN N_Q2_B N_DIFF_E QNPN
Q3 N_MIRROR_REF N_MIRROR_REF +12V QPNP
Q4 N_VAS_IN N_MIRROR_REF +12V QPNP
Q5 N_VAS_OUT N_VAS_IN +12V QPNP
Q6 N_VAS_OUT N_BIAS_ADJ N_PNP_BASE QNPN
Q7 +12V N_VAS_OUT N_OUT_RAW QNPN
Q8 -12V N_PNP_BASE N_OUT_RAW QPNP
R1 N_Q1_B 0 22k
R2 N_DIFF_E -12V 10k
R3 OUT N_Q2_B 22k
R4 N_Q2_B 0 1k
R5 N_VAS_OUT N_BIAS_ADJ 1k
R6 N_BIAS_ADJ N_PNP_BASE 680
R7 N_OUT_RAW OUT 0.47
R8 OUT N_OUT_RAW 0.47
R9 N_VAS_OUT -12V 5.6k
R10 OUT 0 8
C1 IN N_Q1_B 7.234321705656284e-07
C2 N_Q2_B 0 47µ
C3 N_VAS_OUT N_VAS_IN 100p
C4 +12V 0 100µ
C5 -12V 0 100µ
.model QNPN NPN(BF=180 IS=1e-14 VAF=100)
.model QPNP PNP(BF=120 IS=1e-14 VAF=80)
VTB IN 0 SINE(0 1 1k)
.tran 1u 5m
.control
run
wrdata output.tsv v(IN) v(OUT)
write output.raw
quit
.endc
.end
