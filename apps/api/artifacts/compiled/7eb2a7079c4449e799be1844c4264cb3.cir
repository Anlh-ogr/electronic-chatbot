* Auto-generated by NgspiceCompilerService
RVCC VCC 0 12V
RGND 0 0 0V
RIN IN_NET 0 Signal_Input
ROUT OUT_NET 0 Signal_Output
Q1 COLLECTOR_NET BASE_NET EMITTER_NET QNPN
R1 VCC BASE_NET 100k
R2 BASE_NET 0 22k
RC VCC COLLECTOR_NET 2.2k
RE1 EMITTER_NET EMITTER_SPLIT_NET 100
RE2 EMITTER_SPLIT_NET 0 680
CIN IN_NET BASE_NET 1uF
COUT COLLECTOR_NET OUT_NET 4.7uF
CE EMITTER_SPLIT_NET 0 100uF
.model QNPN NPN(BF=180 IS=1e-14 VAF=100)
VTB IN 0 SINE(0 1 1k)
.tran 1u 5m
.control
run
wrdata output.tsv v(IN) v(OUT)
write output.raw
quit
.endc
.end
