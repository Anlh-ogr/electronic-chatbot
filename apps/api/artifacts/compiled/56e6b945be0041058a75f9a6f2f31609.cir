* Auto-generated by NgspiceCompilerService
RVCC VCC 0 1k
RGND 0 0 1k
RIN IN 0 1k
ROUT OUT 0 1k
Q1 NET-_Q1-C_ NET-_Q1-B_ NET-_Q1-E_ QNPN
R1 VCC NET-_Q1-B_ 180k
R2 NET-_Q1-B_ 0 43k
RC VCC NET-_Q1-C_ 4.3k
RE1 NET-_Q1-E_ NET-_RE1-2_ 220
RE2 NET-_RE1-2_ 0 1.2k
CIN IN NET-_Q1-B_ 1uF
COUT NET-_Q1-C_ OUT 1uF
CE NET-_RE1-2_ 0 22uF
.model QNPN NPN(BF=180 IS=1e-14 VAF=100)
VVCC VCC 0 DC +12
VTB IN 0 SINE(0 1 1k)
.tran 1u 5m
.control
run
wrdata output.tsv v(IN) v(OUT)
write output.raw
quit
.endc
.end
