* Auto-generated by NgspiceCompilerService
RVCC VCC 0 12V
RGND 0 0 0V
RIN N_IN 0 Signal_Input
ROUT N_OUT 0 Signal_Output
Q1 N_COLLECTOR N_BASE N_EMITTER_TOP QNPN
R1 VCC N_BASE 47k
R2 N_BASE 0 11k
RC VCC N_COLLECTOR 2.2k
RE1 N_EMITTER_TOP N_EMITTER_BOTTOM 680
RE2 N_EMITTER_BOTTOM 0 100
CIN N_IN N_BASE 2.2uF
COUT N_COLLECTOR N_OUT 1uF
CE N_EMITTER_TOP N_EMITTER_BOTTOM 100uF
C_DECOUPLING VCC 0 0.1uF
.model QNPN NPN(BF=180 IS=1e-14 VAF=100)
VTB IN 0 SINE(0 1 1k)
.tran 1u 5m
.control
run
wrdata output.tsv v(IN) v(OUT)
write output.raw
quit
.endc
.end
