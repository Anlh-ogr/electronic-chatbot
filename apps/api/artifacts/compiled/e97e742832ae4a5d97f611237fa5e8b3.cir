* Auto-generated by NgspiceCompilerService
RVCC VCC 0 12V
RGND 0 0 0V
RIN IN_SIGNAL 0 Input
ROUT OUT_SIGNAL 0 Output
Q1 COLLECTOR_Q1 BASE_Q1 EMITTER_Q1 QNPN
R1 VCC BASE_Q1 200kOhm
R2 BASE_Q1 0 43kOhm
RC VCC COLLECTOR_Q1 4.7kOhm
RE1 EMITTER_Q1 EMITTER_SPLIT 200Ohm
RE2 EMITTER_SPLIT 0 1.3kOhm
C_IN IN_SIGNAL BASE_Q1 1uF
C_OUT COLLECTOR_Q1 OUT_SIGNAL 1uF
C_E EMITTER_SPLIT 0 100uF
.model QNPN NPN(BF=180 IS=1e-14 VAF=100)
VTB IN 0 SINE(0 1 1k)
.tran 1u 5m
.control
run
wrdata output.tsv v(IN) v(OUT)
write output.raw
quit
.endc
.end
