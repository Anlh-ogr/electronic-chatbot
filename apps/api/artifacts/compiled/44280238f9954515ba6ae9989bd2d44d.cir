* Auto-generated by NgspiceCompilerService
Q1 N_COLLECTOR N_BASE N_EMITTER QNPN
R1 VCC N_BASE 91k
R2 N_BASE 0 20k
RC VCC N_COLLECTOR 3k
RE1 N_EMITTER N_EMITTER_JUNCTION 300
RE2 N_EMITTER_JUNCTION 0 330
CIN IN N_BASE 1µF
COUT N_COLLECTOR OUT 1µF
CE N_EMITTER_JUNCTION 0 220µF
.model QNPN NPN(BF=180 IS=1e-14 VAF=100)
VTB IN 0 SINE(0 1 1k)
.tran 1u 5m
.control
run
wrdata output.tsv v(IN) v(OUT)
write output.raw
quit
.endc
.end
