* Auto-generated by NgspiceCompilerService
RVCC VCC 0 12V
RGND 0 0 0V
RIN NET-_IN-CIN_ 0 Input
ROUT NET-_COUT-OUT_ 0 Output
Q1 NET-_RC-Q1C_ NET-_R1-R2_ NET-_RE1-RE2_ QNPN
R1 VCC NET-_CIN-Q1B_ 47kOhm
R2 NET-_R1-R2_ 0 10kOhm
RC VCC NET-_RC-Q1C_ 3kOhm
RE1 NET-_RE1-RE2_ 0 150Ohm
RE2 NET-_RE1-RE2_ 0 600Ohm
CIN NET-_IN-CIN_ NET-_CIN-Q1B_ 2.2uF
COUT NET-_RC-Q1C_ NET-_COUT-OUT_ 1uF
CE NET-_RE1-RE2_ 0 100uF
C_DEC VCC 0 0.1uF
.model QNPN NPN(BF=180 IS=1e-14 VAF=100)
VTB IN 0 SINE(0 1 1k)
.tran 1u 5m
.control
run
wrdata output.tsv v(IN) v(OUT)
write output.raw
quit
.endc
.end
