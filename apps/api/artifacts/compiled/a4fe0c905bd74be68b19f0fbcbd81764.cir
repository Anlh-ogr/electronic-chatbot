* Auto-generated by NgspiceCompilerService
CU1 IN 0 LM741
Q1 N2 N2 OUT QNPN
Q2 N2 N2 OUT QPNP
RVCC VCC 0 1k
RGND 0 0 1k
RIN IN 0 1
ROUT OUT 0 1
.model QNPN NPN(BF=180 IS=1e-14 VAF=100)
.model QPNP PNP(BF=120 IS=1e-14 VAF=80)
VVCC VCC 0 DC 15
VTB IN 0 SINE(0 1 1k)
.tran 1u 5m
.control
run
wrdata output.tsv v(IN) v(OUT)
write output.raw
quit
.endc
.end
