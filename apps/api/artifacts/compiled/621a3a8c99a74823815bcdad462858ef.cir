* Auto-generated by NgspiceCompilerService
RVCC VCC 0 12V
RGND 0 0 0V
RIN N_IN 0 Signal_Input
ROUT N_OUT 0 Signal_Output
Q1 N_COLLECTOR N_BASE N_EMITTER_SPLIT QNPN
R1 VCC N_BASE 200k
R2 N_BASE 0 43k
RC VCC N_COLLECTOR 4.7k
RE1 N_EMITTER_SPLIT N_EMITTER_GND 220
RE2 N_EMITTER_GND 0 1.2k
C1 N_IN N_BASE 1uF
C2 N_COLLECTOR N_OUT 10uF
C3 N_EMITTER_GND 0 10uF
C4 VCC 0 0.1uF
.model QNPN NPN(BF=180 IS=1e-14 VAF=100)
VTB IN 0 SINE(0 1 1k)
.tran 1u 5m
.control
run
wrdata output.tsv v(IN) v(OUT)
write output.raw
quit
.endc
.end
