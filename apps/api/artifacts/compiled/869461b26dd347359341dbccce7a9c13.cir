* Auto-generated by NgspiceCompilerService
RVCC VCC 0 12V
RGND 0 0 0V
RIN IN_SIGNAL 0 Input
ROUT OUT_SIGNAL 0 Output
Q1 COLLECTOR_NODE BASE_NODE EMITTER_NODE QNPN
R1 VCC BASE_NODE 47k
R2 BASE_NODE 0 10k
RC VCC COLLECTOR_NODE 3k
RE1 EMITTER_NODE EMITTER_BYPASS_NODE 150
RE2 EMITTER_BYPASS_NODE 0 600
CIN IN_SIGNAL BASE_NODE 2.2uF
COUT COLLECTOR_NODE OUT_SIGNAL 1uF
CE EMITTER_BYPASS_NODE 0 100uF
C_DEC_1 VCC 0 0.1uF
C_DEC_2 VCC 0 10uF
.model QNPN NPN(BF=180 IS=1e-14 VAF=100)
VTB IN 0 SINE(0 1 1k)
.tran 1u 5m
.control
run
wrdata output.tsv v(IN) v(OUT)
write output.raw
quit
.endc
.end
