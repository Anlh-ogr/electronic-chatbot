* Auto-generated by NgspiceCompilerService
Q1 BASE EMIT COL QNPN
R1 VCC BASE 47k
R2 BASE 0 10k
RC VCC COL 6k
RE1 EMIT EMIT_BYPASS 470
RE2 EMIT_BYPASS 0 130
C1 IN BASE 10uF
C2 COL OUT 10uF
C3 EMIT_BYPASS 0 100uF
RVCC VCC 0 12V
RGND 0 0 0
.model QNPN NPN(BF=180 IS=1e-14 VAF=100)
VTB IN 0 SINE(0 1 1k)
.tran 1u 5m
.control
run
wrdata output.tsv v(IN) v(OUT)
write output.raw
quit
.endc
.end
