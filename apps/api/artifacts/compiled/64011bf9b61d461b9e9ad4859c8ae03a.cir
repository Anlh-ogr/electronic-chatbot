* Auto-generated by NgspiceCompilerService
CU1 U1_NONINV_IN U1_INV_IN LM741
R1 IN_MINUS_NET U1_INV_IN 10k
R2 U1_INV_IN U1_OUT_NET 50k
R3 IN_PLUS_NET U1_NONINV_IN 10k
R4 0 0 50k
C1 VCC 0 0.1uF
C2 VEE 0 0.1uF
RVCC VCC 0 +12V
RVEE VEE 0 -12V
RGND 0 0 1k
RIN_PLUS IN_PLUS_NET 0 Input_Plus
RIN_MINUS IN_MINUS_NET 0 Input_Minus
ROUT U1_OUT_NET 0 1k
VVCC VCC 0 DC -12
VTB IN_PLUS_NET 0 SINE(0 1 1k)
.tran 1u 5m
.control
run
wrdata output.tsv v(IN_PLUS_NET) v(OUT)
write output.raw
quit
.endc
.end
