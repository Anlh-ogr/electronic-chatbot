* Auto-generated by NgspiceCompilerService
Q1 VCC N_VAS_OUT N_AMP_OUT QNPN
Q2 VEE N_Q2_B N_AMP_OUT QPNP
Q3 N_VAS_OUT N_Q3_B N_Q3_E QNPN
D1 N_VAS_OUT N_BIAS_MID DDEFAULT
D2 N_BIAS_MID N_Q2_B DDEFAULT
R1 VCC N_Q3_B 150k
R2 N_Q3_B 0 10k
R3 VCC N_VAS_OUT 2.2k
R4 N_Q2_B VEE 2.7k
R5 N_AMP_OUT N_Q3_E 22k
R6 N_Q3_E 0 1k
R7 N_AMP_OUT 0 0.47
R8 N_AMP_OUT 0 0.47
C1 IN N_Q3_B 1µF
C2 N_Q3_E 0 47µF
C3 N_AMP_OUT OUT 1000µF
C4 VCC 0 100µF
C5 VEE 0 100µF
C6 VCC 0 100nF
C7 VEE 0 100nF
.model QNPN NPN(BF=180 IS=1e-14 VAF=100)
.model QPNP PNP(BF=120 IS=1e-14 VAF=80)
.model DDEFAULT D(IS=1e-14 N=1.9)
VTB IN 0 SINE(0 1 1k)
.tran 1u 5m
.control
run
wrdata output.tsv v(IN) v(N_VAS_OUT)
write output.raw
quit
.endc
.end
