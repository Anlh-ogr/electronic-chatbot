* Auto-generated by NgspiceCompilerService
RVCC VCC 0 12V
RGND 0 0 0V
RIN IN_SIGNAL 0 Input
ROUT OUT_SIGNAL 0 Output
Q1 NET_COLLECTOR NET_BASE NET_EMITTER QNPN
R1 VCC NET_BASE 200k
R2 NET_BASE 0 33k
RC VCC NET_COLLECTOR 5.6k
RE1 NET_EMITTER NET_RE_JUNCTION 270
RE2 NET_RE_JUNCTION 0 750
CIN IN_SIGNAL NET_BASE 1uF
COUT NET_COLLECTOR OUT_SIGNAL 1uF
CE NET_RE_JUNCTION 0 10uF
C_VCC VCC 0 1uF
.model QNPN NPN(BF=180 IS=1e-14 VAF=100)
VTB IN 0 SINE(0 1 1k)
.tran 1u 5m
.control
run
wrdata output.tsv v(IN) v(OUT)
write output.raw
quit
.endc
.end
