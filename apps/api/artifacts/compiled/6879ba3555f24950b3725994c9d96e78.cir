* Auto-generated by NgspiceCompilerService
Q1 +12V N_VAS_C N_Q1_E QNPN
Q2 -12V N_Q2_B N_Q2_E QPNP
Q3 N_VAS_C N_INPUT N_VAS_E QNPN
D1 N_VAS_C N_BIAS_MID DDEFAULT
D2 N_BIAS_MID N_Q2_B DDEFAULT
CIN IN N_INPUT 2.2µF
R_IN_BIAS N_INPUT 0 22kΩ
R_VAS_C +12V N_VAS_C 2.2kΩ
R_PULL_DOWN N_Q2_B -12V 5.6kΩ
RF OUT N_VAS_E 22kΩ
RI N_VAS_E N_FB_BOT 1kΩ
C_FB N_FB_BOT 0 22µF
RE1 N_Q1_E OUT 0.47Ω
RE2 N_Q2_E OUT 0.47Ω
R_ZOBEL OUT N_ZOBEL 10Ω
C_ZOBEL N_ZOBEL 0 100nF
RL OUT 0 8Ω
C_PSU_BULK1 +12V 0 1000µF
C_PSU_BULK2 -12V 0 1000µF
.model QNPN NPN(BF=180 IS=1e-14 VAF=100)
.model QPNP PNP(BF=120 IS=1e-14 VAF=80)
.model DDEFAULT D(IS=1e-14 N=1.9)
VTB IN 0 SINE(0 1 1k)
.tran 1u 5m
.control
run
wrdata output.tsv v(IN) v(OUT)
write output.raw
quit
.endc
.end
