* Auto-generated by NgspiceCompilerService
RVCC VCC 0 1k
RGND 0 0 1k
RIN INPUT_SIGNAL 0 1k
ROUT OUTPUT_SIGNAL 0 1k
Q1 COLLECTOR_NODE BASE_NODE EMITTER_NODE QNPN
R1 VCC BASE_NODE 200k
R2 BASE_NODE 0 33k
RC VCC COLLECTOR_NODE 4.7k
RE1 EMITTER_NODE EMITTER_BYPASS_NODE 220
RE2 EMITTER_BYPASS_NODE 0 750
CIN INPUT_SIGNAL BASE_NODE 1uF
COUT COLLECTOR_NODE OUTPUT_SIGNAL 1uF
CE EMITTER_BYPASS_NODE 0 10uF
.model QNPN NPN(BF=180 IS=1e-14 VAF=100)
VVCC VCC 0 DC +12
VTB INPUT_SIGNAL 0 SINE(0 1 1k)
.tran 1u 5m
.control
run
wrdata output.tsv v(INPUT_SIGNAL) v(OUT)
write output.raw
quit
.endc
.end
