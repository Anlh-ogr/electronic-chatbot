* Auto-generated by NgspiceCompilerService
RVCC VCC 0 1k
RGND 0 0 1k
RIN IN_SIG 0 1k
ROUT OUT_SIG 0 1k
Q1 COLLECTOR BASE EMITTER QNPN
R1 VCC BASE 100k
R2 BASE 0 16k
RC VCC COLLECTOR 2.4k
RE1 EMITTER 0 100
RE2 EMITTER 0 390
CIN IN_SIG BASE 1uF
COUT COLLECTOR OUT_SIG 1uF
CE EMITTER 0 100uF
.model QNPN NPN(BF=180 IS=1e-14 VAF=100)
VVCC VCC 0 DC +12
VTB IN_SIG 0 SINE(0 1 1k)
.tran 1u 5m
.control
run
wrdata output.tsv v(IN_SIG) v(OUT_SIG)
write output.raw
quit
.endc
.end
