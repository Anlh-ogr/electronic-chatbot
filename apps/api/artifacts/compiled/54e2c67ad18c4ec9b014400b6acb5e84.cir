* Auto-generated by NgspiceCompilerService
Q1 BASE COLLECTOR EMITTER QNPN
R1 VCC BASE 47k
R2 BASE 0 10k
RC VCC COLLECTOR 3.3k
RE1 EMITTER 0 330
RE2 EMITTER 0 470
C1 IN BASE 10uF
C2 COLLECTOR OUT 10uF
CE EMITTER 0 47uF
RVCC VCC 0 12V
RGND 0 0 0
.model QNPN NPN(BF=180 IS=1e-14 VAF=100)
VTB IN 0 SINE(0 1 1k)
.tran 1u 5m
.control
run
wrdata output.tsv v(IN) v(OUT)
write output.raw
quit
.endc
.end
