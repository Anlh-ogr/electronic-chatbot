* Auto-generated by NgspiceCompilerService
Q1 Q1_B Q1_C Q1_E QNPN
R1 +12V Q1_B 100k
R2 Q1_B 0 22k
RC +12V Q1_C 2.2k
RE1 Q1_E RE_SPLIT 220
RE2 RE_SPLIT 0 390
C1 IN Q1_B 1uF
C2 OUT Q1_C 1uF
CE RE_SPLIT 0 47uF
RVCC +12V 0 +12V
RGND 0 0 GND
.model QNPN NPN(BF=180 IS=1e-14 VAF=100)
VTB IN 0 SINE(0 1 1k)
.tran 1u 5m
.control
run
wrdata output.tsv v(IN) v(OUT)
write output.raw
quit
.endc
.end
