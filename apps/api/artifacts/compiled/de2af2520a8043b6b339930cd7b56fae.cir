* Auto-generated by NgspiceCompilerService
Q1 BASE EMIT COL QNPN
R1 VCC BASE 47k
R2 BASE 0 10k
RC VCC COL 4.7k
RE1 EMIT 0 470
RE2 EMIT 0 100
CE EMIT 0 100uF
RVCC VCC 0 12V
RGND 0 0 0
.model QNPN NPN(BF=180 IS=1e-14 VAF=100)
VTB VCC 0 SINE(0 1 1k)
.tran 1u 5m
.control
run
wrdata output.tsv v(VCC) v(BASE)
write output.raw
quit
.endc
.end
