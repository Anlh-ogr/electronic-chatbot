* Auto-generated by NgspiceCompilerService
Q1 BASE EMITTER COLLECTOR QNPN
R1 BASE VCC 47k
R2 BASE 0 10k
RC VCC COLLECTOR 3k
RE1 EMITTER BYPASS 300
RE2 EMITTER 0 100
C1 IN BASE 10uF
C2 BYPASS 0 47uF
C3 COLLECTOR OUT 10uF
RVCC VCC 0 12V
RGND 0 0 0V
.model QNPN NPN(BF=180 IS=1e-14 VAF=100)
VTB IN 0 SINE(0 1 1k)
.tran 1u 5m
.control
run
wrdata output.tsv v(IN) v(OUT)
write output.raw
quit
.endc
.end
