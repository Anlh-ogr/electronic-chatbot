* Auto-generated by NgspiceCompilerService
RVCC +12V 0 +12V
RGND 0 0 GND
Q1 BASE COLLECTOR EMITTER1 QNPN
R1 +12V BASE 180k
R2 BASE 0 39k
RC +12V COLLECTOR 4.7k
RE1 EMITTER1 EMITTER2 470
RE2 EMITTER2 0 680
C1 IN BASE 1uF
C2 COLLECTOR OUT 1uF
C3 EMITTER2 0 47uF
.model QNPN NPN(BF=180 IS=1e-14 VAF=100)
VTB IN 0 SINE(0 1 1k)
.tran 1u 5m
.control
run
wrdata output.tsv v(IN) v(OUT)
write output.raw
quit
.endc
.end
