* Auto-generated by NgspiceCompilerService
Q1 BASE EMIT COLL QNPN
R1 VCC BASE 47k
R2 BASE 0 10k
RC VCC COLL 4.7k
RE EMIT 0 470
C1 IN BASE 10uF
C2 COLL 0 10uF
RV1 VCC 0 12V
.model QNPN NPN(BF=180 IS=1e-14 VAF=100)
VTB IN 0 SINE(0 1 1k)
.tran 1u 5m
.control
run
wrdata output.tsv v(IN) v(VCC)
write output.raw
quit
.endc
.end
