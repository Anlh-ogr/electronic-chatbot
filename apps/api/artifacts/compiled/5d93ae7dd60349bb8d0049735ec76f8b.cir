* Auto-generated by NgspiceCompilerService
RVCC VCC 0 1k
RGND 0 0 1k
RIN NET-_C1-1_ 0 1k
ROUT NET-_C2-2_ 0 1k
Q1 NET-_RC-2_ NET-_R1-2_ NET-_Q1-E_ QNPN
R1 VCC NET-_C1-2_ 51k
R2 NET-_R1-2_ 0 8.2k
RC VCC NET-_RC-2_ 3k
RE1 NET-_Q1-E_ NET-_RE1-2_ 150
RE2 NET-_RE1-2_ NET-_CE-2_ 330
C1 NET-_C1-1_ NET-_C1-2_ 2.2uF
C2 NET-_RC-2_ NET-_C2-2_ 4.7uF
CE NET-_RE1-2_ NET-_CE-2_ 220uF
C3 VCC 0 0.1uF
.model QNPN NPN(BF=180 IS=1e-14 VAF=100)
VVCC VCC 0 DC +12
VTB VCC 0 SINE(0 1 1k)
.tran 1u 5m
.control
run
wrdata output.tsv v(VCC) v(OUT)
write output.raw
quit
.endc
.end
