* Auto-generated by NgspiceCompilerService
RVCC VCC 0 1k
RGND 0 0 1k
RIN NET_IN 0 1k
ROUT NET_OUT 0 1k
Q1 NET_COLLECTOR NET_BASE NET_EMITTER QNPN
R1 VCC NET_BASE 100k
R2 NET_BASE 0 22k
R3 VCC NET_COLLECTOR 3k
R4 NET_EMITTER 0 620
R5 NET_EMITTER NET_EMITTER_BYPASS 150
C1 NET_IN NET_BASE 1uF
C2 NET_COLLECTOR NET_OUT 10uF
C3 NET_EMITTER_BYPASS 0 100uF
.model QNPN NPN(BF=180 IS=1e-14 VAF=100)
VVCC VCC 0 DC +12
VTB NET_IN 0 SINE(0 1 1k)
.tran 1u 5m
.control
run
wrdata output.tsv v(NET_IN) v(NET_OUT)
write output.raw
quit
.endc
.end
