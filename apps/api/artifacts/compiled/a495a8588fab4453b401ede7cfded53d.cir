* Auto-generated by NgspiceCompilerService
RVCC VCC 0 12V
RGND 0 0 0V
RIN IN_SIGNAL 0 Input
ROUT OUT_SIGNAL 0 Output
Q1 COLLECTOR_NODE BASE_BIAS EMITTER_NODE QNPN
R1 VCC BASE_BIAS 47k
R2 BASE_BIAS 0 10k
RC VCC COLLECTOR_NODE 2.2k
RE1 EMITTER_NODE EMITTER_SPLIT 100ohm
RE2 EMITTER_SPLIT 0 680ohm
CIN IN_SIGNAL BASE_BIAS 2.2uF
COUT COLLECTOR_NODE OUT_SIGNAL 1uF
CE EMITTER_SPLIT 0 22uF
.model QNPN NPN(BF=180 IS=1e-14 VAF=100)
VTB IN 0 SINE(0 1 1k)
.tran 1u 5m
.control
run
wrdata output.tsv v(IN) v(OUT)
write output.raw
quit
.endc
.end
