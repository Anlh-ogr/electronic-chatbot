* Auto-generated by NgspiceCompilerService
Q1 BASE EMITTER COLLECTOR QNPN
R1 BASE VCC 47k
R2 BASE 0 10k
RC VCC COLLECTOR 2.2k
RE1 EMITTER RE_NODE 220
RE2 RE_NODE 0 100
C1 IN BASE 10uF
C2 COLLECTOR OUT 10uF
CE RE_NODE 0 47uF
RVCC VCC 0 12V
RGND 0 0 0
.model QNPN NPN(BF=180 IS=1e-14 VAF=100)
VTB IN 0 SINE(0 1 1k)
.tran 1u 5m
.control
run
wrdata output.tsv v(IN) v(OUT)
write output.raw
quit
.endc
.end
