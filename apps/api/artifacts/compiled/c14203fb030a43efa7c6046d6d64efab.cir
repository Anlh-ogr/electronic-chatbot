* Auto-generated by NgspiceCompilerService
Q1 N2 IN N1 QNPN
Q2 N2 N1 N2 QNPN
R1 VCC 0 10k
R2 0 0 2.2k
RC VCC OUT 1k
RVCC VCC 0 1k
RGND 0 0 1k
RCIN IN 0 1
.model QNPN NPN(BF=180 IS=1e-14 VAF=100)
VVCC VCC 0 DC +12
VTB IN 0 SINE(0 1 1k)
.tran 1u 5m
.control
run
wrdata output.tsv v(IN) v(OUT)
write output.raw
quit
.endc
.end
