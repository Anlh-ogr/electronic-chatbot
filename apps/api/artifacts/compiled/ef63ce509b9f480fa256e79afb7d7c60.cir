* Auto-generated by NgspiceCompilerService
CU1 INPUT_SIGNAL FEEDBACK_NODE LM358
R1 FEEDBACK_NODE 0 1k
R2 OUTPUT_SIGNAL FEEDBACK_NODE 10k
C1 VCC 0 0.1uF
RVCC VCC 0 1k
RGND 0 0 1k
RIN INPUT_SIGNAL 0 1k
ROUT OUTPUT_SIGNAL 0 1k
VVCC VCC 0 DC +12
VTB INPUT_SIGNAL 0 SINE(0 1 1k)
.tran 1u 5m
.control
run
wrdata output.tsv v(INPUT_SIGNAL) v(OUT)
write output.raw
quit
.endc
.end
